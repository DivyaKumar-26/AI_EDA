* CircuitPilot first-order RC low-pass
V1 in 0 AC 1
R1 in out 1000
C1 out 0 2.2e-07
.ac dec 100 1 1Meg
.end
