* CircuitPilot non-inverting op-amp amplifier, nominal gain 11 V/V
VIN in 0 DC 0 AC 1
RG fb 0 10k
RF out fb 100k
XU1 in fb out CP_OPAMP
.subckt CP_OPAMP INP INM OUT
BOL NRAW 0 V=limit(100000*(V(INP)-V(INM)),-14,14)
RDOM NRAW NCOMP 1k
CDOM NCOMP 0 1u
RBIAS NCOMP 0 1Meg
EOUT NBUF 0 NCOMP 0 1
ROUT NBUF OUT 50
RLEAK OUT 0 1G
.ends CP_OPAMP
.ac dec 100 10 100Meg
.end
